** Profile: "SCHEMATIC1-PARAM_sETA"  [ d:\facultate\an 2\semestru 2\cad\proiectul meu_pwm\proiectcad-pspicefiles\schematic1\param_seta.sim ]

** Creating circuit file "PARAM_sETA.cir"
** WARNING: THIS AUTOMATICALLY GENERATED FILE MAY BE OVERWRITTEN BY SUBSEQUENT SIMULATIONS

*Libraries:
* Profile Libraries :
* Local Libraries :
* From [PSPICE NETLIST] section of C:\Users\user\AppData\Roaming\SPB_Data\cdssetup\OrCAD_PSpice\24.1.0\PSpice.ini file:
.lib "nom.lib"

*Analysis directives:
.TRAN  0 300u 0 0.1
.STEP LIN PARAM seta 0 1 0.5
.OPTIONS ADVCONV
.PROBE64 V(alias(*)) I(alias(*)) W(alias(*)) D(alias(*)) NOISE(alias(*))
.INC "..\SCHEMATIC1.net"

.END
